# Ansys Electronics Desktop project, version 2020.1
project variables:
  $teflon_L = 4mm
  $SMA_H = 9.53mm
  $AWG_18_D = 0.0403in
  $SMA_C_Pin_D = 0.05in
  $T = 0.02in
project datasets:
  $ecco_permittivity: (100, 18) (1000, 16) (10000, 15) (100000, 13) (1000000, 11) (10000000, 9) (100000000, 7) (1000000000, 5) (3000000000, 3.2) (8600000000, 3) (10000000000, 2.9) (18000000000, 2.8)
  $ecco_permeability: (100, 1.20184) (1000, 1.20184) (10000, 1.20184) (100000, 1.20065) (1000000, 1.19388) (10000000, 1.17675) (100000000, 1.14447) (1000000000, 1.09224) (3000000000, 1.05891) (8600000000, 1.02118) (10000000000, 1.01529) (18000000000, 1)
  $ecco_tan_e: (100, 0.00908718) (1000, 0.0136308) (10000, 0.0181744) (100000, 0.022718) (1000000, 0.0272615) (10000000, 0.0318051) (100000000, 0.0366006) (1000000000, 0.0446467) (3000000000, 0.0471281) (8600000000, 0.0454211) (10000000000, 0.0446555) (18000000000, 0.0399967)
  $ecco_tan_m: (100, 0) (1000, 0) (10000, 0) (100000, 0) (1000000, 0) (10000000, 0) (100000000, 0) (1000000000, 0) (3000000000, 0.00722906) (8600000000, 0.0899401) (10000000000, 0.108975) (18000000000, 0.19937)
materials:
  vacuum: permittivity=1
  copper: permeability=0.999991 conductivity=58000000
  Teflon (tm): permittivity=2.1 dielectric_loss_tangent=0.001
  gold: permeability=0.99996 conductivity=41000000
  ECCOSORB_CR110: permittivity=pwl($ecco_permittivity,Freq) permeability=pwl($ecco_permeability,Freq) dielectric_loss_tangent=pwl($ecco_tan_e,Freq) magnetic_loss_tangent=pwl($ecco_tan_m,Freq)

design Stripline Filter (HFSS, DrivenModal, model units in)
variables:
  box_x = 1in
  box_y = L+$teflon_l*2
  box_z = (1/4) in
  L = 0.68375in  # optimise 1in..1.6in
  W = 0.826in  # optimise 0.4in..1.2in
  H = 0.2015in  # optimise 0.15in..0.25in
  SMA_z = H/2
  margin = 1.5mm
  fillet = (1/8) in
  width_y = 2.4mm
  S = 0.08975in  # optimise 0.075in..0.125in
  chamfer = (S-0.05in)/2
geometry:
  Box [copper] = box(corner=(-box_x/2, -box_y/2, 0in), size=(box_x, box_y, -box_z))
  Cavity [ECCOSORB_CR110] = box(corner=(-W/2, -L/2, 0in), size=(W, L, -H))
  Lid [copper] = box(corner=(-box_x/2, -box_y/2, 0in), size=(box_x, box_y, 0.06in))
  Cavity.fillet(Edges=Cavity.edge(10 of 12, 9 of 12, 11 of 12, 12 of 12) Radius=fillet Setback=0in)
  Cavity_1 = Cavity.copy()
  Box.subtract(Cavity_1)
  SMA_C_Pin [gold] = imported_body(C:\Users\simpl\Desktop\Models\SMA\132143_3d_model.igs)
  SMA_Teflon [Teflon (tm)] = cylinder(axis=X, base_centre=(0mm, 0mm, 0mm), radius=2.125mm, height=13.53mm)
  Cylinder1_1 = SMA_Teflon.copy()
  SMA_C_Pin.subtract(Cylinder1_1)
  SMA_Body [gold] = SMA_C_Pin.split(plane=Teflon_1.face(3 of 3), keep=Both)
  C_Pin1 = cylinder(axis=X, base_centre=(0mm, 0mm, 0mm), radius=0.635mm, height=16.53mm)
  C_Pin_1 = C_Pin1.copy()
  SMA_C_Pin.unite(C_Pin1)
  Teflon_1 = SMA_Teflon.copy()
  SMA_Teflon.subtract(C_Pin_1)
  Teflon_1.delete()
  [SMA_C_Pin, SMA_Teflon, SMA_Body].rotate(axis=Z, angle=90deg)
  [SMA_C_Pin, SMA_Teflon, SMA_Body].rotate(axis=Y, angle=90deg)
  [SMA_C_Pin, SMA_Teflon, SMA_Body].move(0in, -box_y/2-$SMA_H, -SMA_z)
  SMA_C_Pin_1 [gold] = SMA_C_Pin.duplicate_around_axis(axis=Z, angle=180deg, total=2)
  SMA_Teflon_1 [Teflon (tm)] = SMA_Teflon.duplicate_around_axis(axis=Z, angle=180deg, total=2)
  SMA_Body_1 [gold] = SMA_Body.duplicate_around_axis(axis=Z, angle=180deg, total=2)
  SMA_C_Pin_2 = SMA_C_Pin.copy()
  SMA_C_Pin_1_1 = SMA_C_Pin_1.copy()
  SMA_Teflon_2 = SMA_Teflon.copy()
  SMA_Teflon_1_1 = SMA_Teflon_1.copy()
  Box.subtract(SMA_C_Pin_2, SMA_C_Pin_1_1, SMA_Teflon_2, SMA_Teflon_1_1)
  Strip [copper] = box(corner=(-S/2, -L/2+margin, -H/2), size=(S, L-margin*2, $T))
  Strip.chamfer(Edges=Strip.edge(10 of 12, 9 of 12, 12 of 12, 11 of 12) LeftDistance=chamfer RightDistance=chamfer ChamferType=Symmetric)
  SMA_Copper = imported_body(C:\Users\simpl\Desktop\Models\SMA\132143_3d_model.igs)
  Teflon = cylinder(axis=X, base_centre=(0mm, 0mm, 0mm), radius=2.125mm, height=9.53mm)
  Cylinder1_2 = Teflon.copy()
  SMA_Copper.subtract(Cylinder1_2)
  SMA_Copper.split(plane=Teflon_2.face(3 of 3), keep=Both)
  C_Pin = cylinder(axis=X, base_centre=(0mm, 0mm, 0mm), radius=0.635mm, height=9.53mm)
  SMA_Copper.unite(C_Pin)
  SMA_Copper.rotate(axis=Z, angle=90deg)
  SMA_Copper.rotate(axis=Y, angle=-90deg)
  SMA_Copper.move(0mm, -box_y/2-$SMA_H, 0mm)
  SMA_Copper_1 = SMA_Copper.duplicate_around_axis(axis=Z, angle=180deg, total=2)
  SMA_Copper_3 = SMA_Copper.copy()
  SMA_Copper_1_2 = SMA_Copper_1.copy()
  Strip.subtract(SMA_Copper_3, SMA_Copper_1_2)
  [SMA_Copper, SMA_Copper_1].delete()
  Teflon_2 = Teflon.copy()
  [Teflon, Teflon_2].delete()
  Strip_1 = Strip.copy()
  SMA_C_Pin.subtract(Strip_1)
  Strip_2 = Strip.copy()
  SMA_C_Pin_1.subtract(Strip_2)
  SMA_C_Pin_3 = SMA_C_Pin.copy()
  SMA_C_Pin_1_2 = SMA_C_Pin_1.copy()
  Strip_3 = Strip.copy()
  Cavity.subtract(SMA_C_Pin_3, SMA_C_Pin_1_2, Strip_3)
  group SMA_Connector = SMA_C_Pin, SMA_Teflon, SMA_Body, SMA_C_Pin_1, SMA_Teflon_1, SMA_Body_1
boundaries and excitations:
  1: Wave Port Faces=SMA_Teflon.face(2 of 3) NumModes=1 Modes{Mode1{CharImp=Zpi}}
  2: Wave Port Faces=SMA_Teflon_1.face(3 of 4) NumModes=1 Modes{Mode1{CharImp=Zpi}}
mesh:
  initial mesh: GlobalSurfApproximation{CurvedSurfaceApproxChoice=UseSlider SliderMeshSettings=7}
setups:
  25_85_GHz_Sweep: HfssDriven AdaptMultipleFreqs MultipleAdaptiveFreqsSetup{Broadband{Low=2.5GHz High=8.5GHz}} MaxDeltaS=0.003 MaximumPasses=7 MinimumPasses=1 MinimumConvergedPasses=1 PercentRefinement=30 BasisOrder=1 PortAccuracy=2
    sweep Sweep: 2.5GHz to 8.5GHz, 601 points; Type=Interpolating InterpTolerance=0.2 InterpMaxSolns=250 InterpUsePortImped=false PassivityErrorTolerance=0.0001
  Freq_Sweep: HfssDriven AdaptMultipleFreqs MultipleAdaptiveFreqsSetup{Broadband{Low=0.1GHz High=20GHz}} MaxDeltaS=0.002 MaximumPasses=8 MinimumPasses=1 MinimumConvergedPasses=1 PercentRefinement=30 BasisOrder=1 PortAccuracy=2
    sweep Sweep: 0.1GHz to 20GHz, 996 points; Type=Interpolating InterpTolerance=0.1 InterpMaxSolns=250 InterpUsePortImped=false PassivityErrorTolerance=0.0001
  0_60_GHz: HfssDriven AdaptMultipleFreqs MultipleAdaptiveFreqsSetup{Broadband{Low=0.1GHz High=60GHz}} MaxDeltaS=0.01 MaximumPasses=99 MinimumPasses=1 MinimumConvergedPasses=1 PercentRefinement=30 BasisOrder=1 PortAccuracy=2
    sweep Sweep: 0.1GHz to 60GHz, 1001 points; Type=Interpolating InterpTolerance=0.5 InterpMaxSolns=250 InterpUsePortImped=false PassivityErrorTolerance=0.0001
source amplitudes:
  1:1: 1W 0deg
  2:1: 0W 0deg
optimetrics:
  Min_S11: Optimization Optimizer="Pattern Search" AnalysisStopOptions{StopForNumIteration MaxNumIteration=25 MinNumIteration=10} CostFuncNormType=L2 Acceptable_Cost=-100 Noise=0.0001 UpdateDesignWhenDone
    vary H: Min=0.18in Max=0.23in MinStep=0.0002in MaxStep=0.02in MinFocus=0.15in MaxFocus=0.25in start=0.204in
    vary L: Min=0.4in Max=0.7in MinStep=0.00055in MaxStep=0.055in MinFocus=1in MaxFocus=1.6in start=0.56in
    vary S: Min=0.07in Max=0.11in MinStep=9e-05in MaxStep=0.009in MinFocus=0.075in MaxFocus=0.125in start=0.092in
    vary W: Min=0.6in Max=0.9in MinStep=0.0007in MaxStep=0.07in MinFocus=0.4in MaxFocus=1.2in start=0.756in
    goal avg(dB(S(1,1))) Minimize 0 weight 1 on 25_85_GHz_Sweep : Sweep at Freq 3GHz to 8GHz
reports:
  S Parameter Plot 1: dB(S(1,1)) vs Freq on Freq_Sweep : Sweep
  S Parameter Plot 2: dB(S(2,1)) vs Freq on Freq_Sweep : Sweep [L=all W=all H=all S=all]
  S Parameter Plot 3: dB(S(1,1)) vs Freq on 25_85_GHz_Sweep : Sweep
  S Parameter Plot 4: dB(S(2,1)) vs Freq on 25_85_GHz_Sweep : Sweep
  S Parameter Plot 5: dB(S(1,1)), dB(S(2,1)) vs Freq on 0_60_GHz : Sweep; markers m1 at 39.9934GHz, m2 at 5.9702GHz
